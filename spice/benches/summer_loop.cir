Local loop return ratio and closed-loop transient checks
.include "../models/ADA4899.sub"
.include "../models/opa810/opa810_a.lib"
.include "../models/ths3091_tina/THS3091.lib"
.include "../models/opa197/OPAx197.LIB"
VP vp 0 5
VN vn 0 -5
VHP hp 0 15
VHN hn 0 -15
.options plotwinsize=0 numdgt=7 reltol=0.0001
.param rf=6k ro=6k co=40p cf=2.5p cl=20p
XAMP 0 inn raw vp vn OPA810
RF out inn 523
R1 inn 0 1k
R2 inn 0 1k
R3 inn 0 1k
R4 inn 0 1k
RT inn 0 10k
RR inn 0 20k
CI inn 0 5p
RS out load 49.9
CL load 0 160p
RL load 0 100k
VTEST out raw DC 0 AC 1
.ac dec 150 10 3G
.save V(out) V(raw)
.end
