* Reproducible circuit-level LTspice bench. See MODEL_SCOPE.txt.
.include "../models/opa810/opa810_a.lib"
.include "../models/ths3091_tina/THS3091.lib"
.include "../models/ADA4899.sub"
.include "../models/tmux6219/TMUX6219/TMUX6219.lib"
.include "../models/opa197/OPAx197.LIB"
.param rfb=6k rout=6k cout=35p cstray=5p cfextra=0.3p cload=20p cft=0
VP vp 0 5
VN vn 0 -5
VHP hp 0 15
VHN hn 0 -15
VL logic 0 3.3
VEN SIGNAL_EN 0 3.3
VRUN OUTPUT_RUN 0 3.3
VREF VREF_2V5 0 2.5
.options plotwinsize=0 numdgt=7 reltol=0.0001 abstol=1p vntol=1u
VA0 a0 0 0 AC 1
VA1 a1 0 0 AC 0
VA2 a2 0 0 AC 0
VA3 a3 0 0 AC 0
VSIGN0 SIGN0 0 0
VSIGN1 SIGN1 0 0
VSIGN2 SIGN2 0 0
VSIGN3 SIGN3 0 0
VSIGN4 SIGN4 0 0
VSIGN5 SIGN5 0 0
VSIGN6 SIGN6 0 0
VSIGN7 SIGN7 0 0
VSIGN8 SIGN8 0 0
VSIGN9 SIGN9 0 0
VSIGN10 SIGN10 0 0
VSIGN11 SIGN11 0 0
VSIGN12 SIGN12 0 0
VSIGN13 SIGN13 0 0
VSIGN14 SIGN14 0 0
VSIGN15 SIGN15 0 0
VT0 VTRIM0 0 -1.25
VT1 VTRIM1 0 -1.25
VT2 VTRIM2 0 -1.25
VT3 VTRIM3 0 -1.25
R1 a0 AIN0 33 ; RIN_0
R2 a0 0 1meg ; RBIAS_0
XU1 AIN0 BUF0 BUF0 vp vn OPA810
C1 vp 0 100n ; C_U1_P
C2 vn 0 100n ; C_U1_N
XU2 PDIV0 PN0 P0 vp vn OPA810
C3 vp 0 100n ; C_U2_P
C4 vn 0 100n ; C_U2_N
R4 BUF0 PDIV0 499 ; RPDIVT_0
R5 PDIV0 0 499 ; RPDIVB_0
R6 PN0 P0 1.00k ; RPF_0
R7 0 PN0 1.00k ; RPG_0
XU3 0 NN0 N0 vp vn OPA810
C5 vp 0 100n ; C_U3_P
C6 vn 0 100n ; C_U3_N
R8 BUF0 NN0 1.00k ; RNI_0
R9 NN0 N0 1.00k ; RNF_0
C7 vp 0 10u ; C_IN0_+5A
C8 vn 0 10u ; C_IN0_-5A
R10 a1 AIN1 33 ; RIN_1
R11 a1 0 1meg ; RBIAS_1
XU4 AIN1 BUF1 BUF1 vp vn OPA810
C9 vp 0 100n ; C_U4_P
C10 vn 0 100n ; C_U4_N
XU5 PDIV1 PN1 P1 vp vn OPA810
C11 vp 0 100n ; C_U5_P
C12 vn 0 100n ; C_U5_N
R13 BUF1 PDIV1 499 ; RPDIVT_1
R14 PDIV1 0 499 ; RPDIVB_1
R15 PN1 P1 1.00k ; RPF_1
R16 0 PN1 1.00k ; RPG_1
XU6 0 NN1 N1 vp vn OPA810
C13 vp 0 100n ; C_U6_P
C14 vn 0 100n ; C_U6_N
R17 BUF1 NN1 1.00k ; RNI_1
R18 NN1 N1 1.00k ; RNF_1
C15 vp 0 10u ; C_IN1_+5A
C16 vn 0 10u ; C_IN1_-5A
R19 a2 AIN2 33 ; RIN_2
R20 a2 0 1meg ; RBIAS_2
XU7 AIN2 BUF2 BUF2 vp vn OPA810
C17 vp 0 100n ; C_U7_P
C18 vn 0 100n ; C_U7_N
XU8 PDIV2 PN2 P2 vp vn OPA810
C19 vp 0 100n ; C_U8_P
C20 vn 0 100n ; C_U8_N
R22 BUF2 PDIV2 499 ; RPDIVT_2
R23 PDIV2 0 499 ; RPDIVB_2
R24 PN2 P2 1.00k ; RPF_2
R25 0 PN2 1.00k ; RPG_2
XU9 0 NN2 N2 vp vn OPA810
C21 vp 0 100n ; C_U9_P
C22 vn 0 100n ; C_U9_N
R26 BUF2 NN2 1.00k ; RNI_2
R27 NN2 N2 1.00k ; RNF_2
C23 vp 0 10u ; C_IN2_+5A
C24 vn 0 10u ; C_IN2_-5A
R28 a3 AIN3 33 ; RIN_3
R29 a3 0 1meg ; RBIAS_3
XU10 AIN3 BUF3 BUF3 vp vn OPA810
C25 vp 0 100n ; C_U10_P
C26 vn 0 100n ; C_U10_N
XU11 PDIV3 PN3 P3 vp vn OPA810
C27 vp 0 100n ; C_U11_P
C28 vn 0 100n ; C_U11_N
R31 BUF3 PDIV3 499 ; RPDIVT_3
R32 PDIV3 0 499 ; RPDIVB_3
R33 PN3 P3 1.00k ; RPF_3
R34 0 PN3 1.00k ; RPG_3
XU12 0 NN3 N3 vp vn OPA810
C29 vp 0 100n ; C_U12_P
C30 vn 0 100n ; C_U12_N
R35 BUF3 NN3 1.00k ; RNI_3
R36 NN3 N3 1.00k ; RNF_3
C31 vp 0 10u ; C_IN3_+5A
C32 vn 0 10u ; C_IN3_-5A
Rref_U20_0 REF_00 0 {rfb}
Cref_U20_0 REF_00 0 5p
Gdac_U20_0 0 IOUT_00 REF_00 0 {0.9999847412109375/rfb}
Rfb_U20_0 IOUT_00 V_00 {rfb}
Rout_U20_0 IOUT_00 0 {rout}
Cout_U20_0 IOUT_00 0 {cout+cstray}
Cft_U20_0 REF_00 IOUT_00 {cft+1e-21}
Rref_U20_1 REF_01 0 {rfb}
Cref_U20_1 REF_01 0 5p
Gdac_U20_1 0 IOUT_01 REF_01 0 {0.9999847412109375/rfb}
Rfb_U20_1 IOUT_01 V_01 {rfb}
Rout_U20_1 IOUT_01 0 {rout}
Cout_U20_1 IOUT_01 0 {cout+cstray}
Cft_U20_1 REF_01 IOUT_01 {cft+1e-21}
Rref_U20_2 REF_02 0 {rfb}
Cref_U20_2 REF_02 0 5p
Gdac_U20_2 0 IOUT_02 REF_02 0 {0.9999847412109375/rfb}
Rfb_U20_2 IOUT_02 V_02 {rfb}
Rout_U20_2 IOUT_02 0 {rout}
Cout_U20_2 IOUT_02 0 {cout+cstray}
Cft_U20_2 REF_02 IOUT_02 {cft+1e-21}
Rref_U20_3 REF_03 0 {rfb}
Cref_U20_3 REF_03 0 5p
Gdac_U20_3 0 IOUT_03 REF_03 0 {0.9999847412109375/rfb}
Rfb_U20_3 IOUT_03 V_03 {rfb}
Rout_U20_3 IOUT_03 0 {rout}
Cout_U20_3 IOUT_03 0 {cout+cstray}
Cft_U20_3 REF_03 IOUT_03 {cft+1e-21}
C33 vp 0 100n ; C_U20_P
C34 vp 0 1u ; CB_U20_P
C35 vn 0 100n ; C_U20_N
C36 vn 0 1u ; CB_U20_N
R37 P0 SWP_00 150 ; RBRP_00
R38 N0 SWN_00 150 ; RBRN_00
XU40 REF_00 SWP_00 0 vp SIGNAL_EN SIGN0 vn SWN_00 TMUX6219
C37 vp 0 100n ; C_U40_P
C38 vn 0 100n ; C_U40_N
R39 SIGN0 0 100k ; RSEL_00
XU60 0 IOUT_00 vp vn V_00 V_00 vp ADA4899
C39 vp 0 100n ; C_U60_P
C40 vn 0 100n ; C_U60_N
C41 IOUT_00 V_00 {2.2e-12+cfextra} ; C_WEIGHT_00
R40 V_00 SN0 1.00k ; RSUM_00
R41 P1 SWP_01 150 ; RBRP_01
R42 N1 SWN_01 150 ; RBRN_01
XU41 REF_01 SWP_01 0 vp SIGNAL_EN SIGN1 vn SWN_01 TMUX6219
C42 vp 0 100n ; C_U41_P
C43 vn 0 100n ; C_U41_N
R43 SIGN1 0 100k ; RSEL_01
XU61 0 IOUT_01 vp vn V_01 V_01 vp ADA4899
C44 vp 0 100n ; C_U61_P
C45 vn 0 100n ; C_U61_N
C46 IOUT_01 V_01 {2.2e-12+cfextra} ; C_WEIGHT_01
R44 V_01 SN0 1.00k ; RSUM_01
R45 P2 SWP_02 150 ; RBRP_02
R46 N2 SWN_02 150 ; RBRN_02
XU42 REF_02 SWP_02 0 vp SIGNAL_EN SIGN2 vn SWN_02 TMUX6219
C47 vp 0 100n ; C_U42_P
C48 vn 0 100n ; C_U42_N
R47 SIGN2 0 100k ; RSEL_02
XU62 0 IOUT_02 vp vn V_02 V_02 vp ADA4899
C49 vp 0 100n ; C_U62_P
C50 vn 0 100n ; C_U62_N
C51 IOUT_02 V_02 {2.2e-12+cfextra} ; C_WEIGHT_02
R48 V_02 SN0 1.00k ; RSUM_02
R49 P3 SWP_03 150 ; RBRP_03
R50 N3 SWN_03 150 ; RBRN_03
XU43 REF_03 SWP_03 0 vp SIGNAL_EN SIGN3 vn SWN_03 TMUX6219
C52 vp 0 100n ; C_U43_P
C53 vn 0 100n ; C_U43_N
R51 SIGN3 0 100k ; RSEL_03
XU63 0 IOUT_03 vp vn V_03 V_03 vp ADA4899
C54 vp 0 100n ; C_U63_P
C55 vn 0 100n ; C_U63_N
C56 IOUT_03 V_03 {2.2e-12+cfextra} ; C_WEIGHT_03
R52 V_03 SN0 1.00k ; RSUM_03
XU80 0 SN0 SUM0 vp vn OPA810
C57 vp 0 100n ; C_U80_P
C58 vn 0 100n ; C_U80_N
R53 SN0 SUM0 523 ; RSF_0
R54 VTRIM0 SN0 10.0k ; RTRIM_0
R55 VREF_2V5 SN0 20.0k ; RREF_0
R56 SUM0 MUTEIN0 49.9 ; RMUTE_0
XU84 DRVIN0 0 0 vp logic OUTPUT_RUN vn MUTEIN0 TMUX6219
C59 vp 0 100n ; C_U84_P
C60 vn 0 100n ; C_U84_N
R57 DRVIN0 0 100k ; RDRVB_0
XU90 DRVIN0 DRVN0 DRV0 hp hn THS3091
C61 hp 0 100n ; C_U90_P
C62 hn 0 100n ; C_U90_N
R58 DRVN0 DRV0 1.21k ; RDF_0
R59 0 DRVN0 402 ; RDG_0
R60 DRV0 b0 49.9 ; R_OUT_0
C63 vp 0 10u ; C_ROW0_P
C64 vn 0 10u ; C_ROW0_N
C65 hp 0 6.8u ; C_DRIVER0_P
C66 0 hn 6.8u ; C_DRIVER0_N
Rref_U21_0 REF_10 0 {rfb}
Cref_U21_0 REF_10 0 5p
Gdac_U21_0 0 IOUT_10 REF_10 0 {0.9999847412109375/rfb}
Rfb_U21_0 IOUT_10 V_10 {rfb}
Rout_U21_0 IOUT_10 0 {rout}
Cout_U21_0 IOUT_10 0 {cout+cstray}
Cft_U21_0 REF_10 IOUT_10 {cft+1e-21}
Rref_U21_1 REF_11 0 {rfb}
Cref_U21_1 REF_11 0 5p
Gdac_U21_1 0 IOUT_11 REF_11 0 {0.9999847412109375/rfb}
Rfb_U21_1 IOUT_11 V_11 {rfb}
Rout_U21_1 IOUT_11 0 {rout}
Cout_U21_1 IOUT_11 0 {cout+cstray}
Cft_U21_1 REF_11 IOUT_11 {cft+1e-21}
Rref_U21_2 REF_12 0 {rfb}
Cref_U21_2 REF_12 0 5p
Gdac_U21_2 0 IOUT_12 REF_12 0 {0.9999847412109375/rfb}
Rfb_U21_2 IOUT_12 V_12 {rfb}
Rout_U21_2 IOUT_12 0 {rout}
Cout_U21_2 IOUT_12 0 {cout+cstray}
Cft_U21_2 REF_12 IOUT_12 {cft+1e-21}
Rref_U21_3 REF_13 0 {rfb}
Cref_U21_3 REF_13 0 5p
Gdac_U21_3 0 IOUT_13 REF_13 0 {0.9999847412109375/rfb}
Rfb_U21_3 IOUT_13 V_13 {rfb}
Rout_U21_3 IOUT_13 0 {rout}
Cout_U21_3 IOUT_13 0 {cout+cstray}
Cft_U21_3 REF_13 IOUT_13 {cft+1e-21}
C67 vp 0 100n ; C_U21_P
C68 vp 0 1u ; CB_U21_P
C69 vn 0 100n ; C_U21_N
C70 vn 0 1u ; CB_U21_N
R61 P0 SWP_10 150 ; RBRP_10
R62 N0 SWN_10 150 ; RBRN_10
XU44 REF_10 SWP_10 0 vp SIGNAL_EN SIGN4 vn SWN_10 TMUX6219
C71 vp 0 100n ; C_U44_P
C72 vn 0 100n ; C_U44_N
R63 SIGN4 0 100k ; RSEL_10
XU64 0 IOUT_10 vp vn V_10 V_10 vp ADA4899
C73 vp 0 100n ; C_U64_P
C74 vn 0 100n ; C_U64_N
C75 IOUT_10 V_10 {2.2e-12+cfextra} ; C_WEIGHT_10
R64 V_10 SN1 1.00k ; RSUM_10
R65 P1 SWP_11 150 ; RBRP_11
R66 N1 SWN_11 150 ; RBRN_11
XU45 REF_11 SWP_11 0 vp SIGNAL_EN SIGN5 vn SWN_11 TMUX6219
C76 vp 0 100n ; C_U45_P
C77 vn 0 100n ; C_U45_N
R67 SIGN5 0 100k ; RSEL_11
XU65 0 IOUT_11 vp vn V_11 V_11 vp ADA4899
C78 vp 0 100n ; C_U65_P
C79 vn 0 100n ; C_U65_N
C80 IOUT_11 V_11 {2.2e-12+cfextra} ; C_WEIGHT_11
R68 V_11 SN1 1.00k ; RSUM_11
R69 P2 SWP_12 150 ; RBRP_12
R70 N2 SWN_12 150 ; RBRN_12
XU46 REF_12 SWP_12 0 vp SIGNAL_EN SIGN6 vn SWN_12 TMUX6219
C81 vp 0 100n ; C_U46_P
C82 vn 0 100n ; C_U46_N
R71 SIGN6 0 100k ; RSEL_12
XU66 0 IOUT_12 vp vn V_12 V_12 vp ADA4899
C83 vp 0 100n ; C_U66_P
C84 vn 0 100n ; C_U66_N
C85 IOUT_12 V_12 {2.2e-12+cfextra} ; C_WEIGHT_12
R72 V_12 SN1 1.00k ; RSUM_12
R73 P3 SWP_13 150 ; RBRP_13
R74 N3 SWN_13 150 ; RBRN_13
XU47 REF_13 SWP_13 0 vp SIGNAL_EN SIGN7 vn SWN_13 TMUX6219
C86 vp 0 100n ; C_U47_P
C87 vn 0 100n ; C_U47_N
R75 SIGN7 0 100k ; RSEL_13
XU67 0 IOUT_13 vp vn V_13 V_13 vp ADA4899
C88 vp 0 100n ; C_U67_P
C89 vn 0 100n ; C_U67_N
C90 IOUT_13 V_13 {2.2e-12+cfextra} ; C_WEIGHT_13
R76 V_13 SN1 1.00k ; RSUM_13
XU81 0 SN1 SUM1 vp vn OPA810
C91 vp 0 100n ; C_U81_P
C92 vn 0 100n ; C_U81_N
R77 SN1 SUM1 523 ; RSF_1
R78 VTRIM1 SN1 10.0k ; RTRIM_1
R79 VREF_2V5 SN1 20.0k ; RREF_1
R80 SUM1 MUTEIN1 49.9 ; RMUTE_1
XU85 DRVIN1 0 0 vp logic OUTPUT_RUN vn MUTEIN1 TMUX6219
C93 vp 0 100n ; C_U85_P
C94 vn 0 100n ; C_U85_N
R81 DRVIN1 0 100k ; RDRVB_1
XU91 DRVIN1 DRVN1 DRV1 hp hn THS3091
C95 hp 0 100n ; C_U91_P
C96 hn 0 100n ; C_U91_N
R82 DRVN1 DRV1 1.21k ; RDF_1
R83 0 DRVN1 402 ; RDG_1
R84 DRV1 b1 49.9 ; R_OUT_1
C97 vp 0 10u ; C_ROW1_P
C98 vn 0 10u ; C_ROW1_N
C99 hp 0 6.8u ; C_DRIVER1_P
C100 0 hn 6.8u ; C_DRIVER1_N
Rref_U22_0 REF_20 0 {rfb}
Cref_U22_0 REF_20 0 5p
Gdac_U22_0 0 IOUT_20 REF_20 0 {0.9999847412109375/rfb}
Rfb_U22_0 IOUT_20 V_20 {rfb}
Rout_U22_0 IOUT_20 0 {rout}
Cout_U22_0 IOUT_20 0 {cout+cstray}
Cft_U22_0 REF_20 IOUT_20 {cft+1e-21}
Rref_U22_1 REF_21 0 {rfb}
Cref_U22_1 REF_21 0 5p
Gdac_U22_1 0 IOUT_21 REF_21 0 {0.9999847412109375/rfb}
Rfb_U22_1 IOUT_21 V_21 {rfb}
Rout_U22_1 IOUT_21 0 {rout}
Cout_U22_1 IOUT_21 0 {cout+cstray}
Cft_U22_1 REF_21 IOUT_21 {cft+1e-21}
Rref_U22_2 REF_22 0 {rfb}
Cref_U22_2 REF_22 0 5p
Gdac_U22_2 0 IOUT_22 REF_22 0 {0.9999847412109375/rfb}
Rfb_U22_2 IOUT_22 V_22 {rfb}
Rout_U22_2 IOUT_22 0 {rout}
Cout_U22_2 IOUT_22 0 {cout+cstray}
Cft_U22_2 REF_22 IOUT_22 {cft+1e-21}
Rref_U22_3 REF_23 0 {rfb}
Cref_U22_3 REF_23 0 5p
Gdac_U22_3 0 IOUT_23 REF_23 0 {0.9999847412109375/rfb}
Rfb_U22_3 IOUT_23 V_23 {rfb}
Rout_U22_3 IOUT_23 0 {rout}
Cout_U22_3 IOUT_23 0 {cout+cstray}
Cft_U22_3 REF_23 IOUT_23 {cft+1e-21}
C101 vp 0 100n ; C_U22_P
C102 vp 0 1u ; CB_U22_P
C103 vn 0 100n ; C_U22_N
C104 vn 0 1u ; CB_U22_N
R85 P0 SWP_20 150 ; RBRP_20
R86 N0 SWN_20 150 ; RBRN_20
XU48 REF_20 SWP_20 0 vp SIGNAL_EN SIGN8 vn SWN_20 TMUX6219
C105 vp 0 100n ; C_U48_P
C106 vn 0 100n ; C_U48_N
R87 SIGN8 0 100k ; RSEL_20
XU68 0 IOUT_20 vp vn V_20 V_20 vp ADA4899
C107 vp 0 100n ; C_U68_P
C108 vn 0 100n ; C_U68_N
C109 IOUT_20 V_20 {2.2e-12+cfextra} ; C_WEIGHT_20
R88 V_20 SN2 1.00k ; RSUM_20
R89 P1 SWP_21 150 ; RBRP_21
R90 N1 SWN_21 150 ; RBRN_21
XU49 REF_21 SWP_21 0 vp SIGNAL_EN SIGN9 vn SWN_21 TMUX6219
C110 vp 0 100n ; C_U49_P
C111 vn 0 100n ; C_U49_N
R91 SIGN9 0 100k ; RSEL_21
XU69 0 IOUT_21 vp vn V_21 V_21 vp ADA4899
C112 vp 0 100n ; C_U69_P
C113 vn 0 100n ; C_U69_N
C114 IOUT_21 V_21 {2.2e-12+cfextra} ; C_WEIGHT_21
R92 V_21 SN2 1.00k ; RSUM_21
R93 P2 SWP_22 150 ; RBRP_22
R94 N2 SWN_22 150 ; RBRN_22
XU50 REF_22 SWP_22 0 vp SIGNAL_EN SIGN10 vn SWN_22 TMUX6219
C115 vp 0 100n ; C_U50_P
C116 vn 0 100n ; C_U50_N
R95 SIGN10 0 100k ; RSEL_22
XU70 0 IOUT_22 vp vn V_22 V_22 vp ADA4899
C117 vp 0 100n ; C_U70_P
C118 vn 0 100n ; C_U70_N
C119 IOUT_22 V_22 {2.2e-12+cfextra} ; C_WEIGHT_22
R96 V_22 SN2 1.00k ; RSUM_22
R97 P3 SWP_23 150 ; RBRP_23
R98 N3 SWN_23 150 ; RBRN_23
XU51 REF_23 SWP_23 0 vp SIGNAL_EN SIGN11 vn SWN_23 TMUX6219
C120 vp 0 100n ; C_U51_P
C121 vn 0 100n ; C_U51_N
R99 SIGN11 0 100k ; RSEL_23
XU71 0 IOUT_23 vp vn V_23 V_23 vp ADA4899
C122 vp 0 100n ; C_U71_P
C123 vn 0 100n ; C_U71_N
C124 IOUT_23 V_23 {2.2e-12+cfextra} ; C_WEIGHT_23
R100 V_23 SN2 1.00k ; RSUM_23
XU82 0 SN2 SUM2 vp vn OPA810
C125 vp 0 100n ; C_U82_P
C126 vn 0 100n ; C_U82_N
R101 SN2 SUM2 523 ; RSF_2
R102 VTRIM2 SN2 10.0k ; RTRIM_2
R103 VREF_2V5 SN2 20.0k ; RREF_2
R104 SUM2 MUTEIN2 49.9 ; RMUTE_2
XU86 DRVIN2 0 0 vp logic OUTPUT_RUN vn MUTEIN2 TMUX6219
C127 vp 0 100n ; C_U86_P
C128 vn 0 100n ; C_U86_N
R105 DRVIN2 0 100k ; RDRVB_2
XU92 DRVIN2 DRVN2 DRV2 hp hn THS3091
C129 hp 0 100n ; C_U92_P
C130 hn 0 100n ; C_U92_N
R106 DRVN2 DRV2 1.21k ; RDF_2
R107 0 DRVN2 402 ; RDG_2
R108 DRV2 b2 49.9 ; R_OUT_2
C131 vp 0 10u ; C_ROW2_P
C132 vn 0 10u ; C_ROW2_N
C133 hp 0 6.8u ; C_DRIVER2_P
C134 0 hn 6.8u ; C_DRIVER2_N
Rref_U23_0 REF_30 0 {rfb}
Cref_U23_0 REF_30 0 5p
Gdac_U23_0 0 IOUT_30 REF_30 0 {0.9999847412109375/rfb}
Rfb_U23_0 IOUT_30 V_30 {rfb}
Rout_U23_0 IOUT_30 0 {rout}
Cout_U23_0 IOUT_30 0 {cout+cstray}
Cft_U23_0 REF_30 IOUT_30 {cft+1e-21}
Rref_U23_1 REF_31 0 {rfb}
Cref_U23_1 REF_31 0 5p
Gdac_U23_1 0 IOUT_31 REF_31 0 {0.9999847412109375/rfb}
Rfb_U23_1 IOUT_31 V_31 {rfb}
Rout_U23_1 IOUT_31 0 {rout}
Cout_U23_1 IOUT_31 0 {cout+cstray}
Cft_U23_1 REF_31 IOUT_31 {cft+1e-21}
Rref_U23_2 REF_32 0 {rfb}
Cref_U23_2 REF_32 0 5p
Gdac_U23_2 0 IOUT_32 REF_32 0 {0.9999847412109375/rfb}
Rfb_U23_2 IOUT_32 V_32 {rfb}
Rout_U23_2 IOUT_32 0 {rout}
Cout_U23_2 IOUT_32 0 {cout+cstray}
Cft_U23_2 REF_32 IOUT_32 {cft+1e-21}
Rref_U23_3 REF_33 0 {rfb}
Cref_U23_3 REF_33 0 5p
Gdac_U23_3 0 IOUT_33 REF_33 0 {0.9999847412109375/rfb}
Rfb_U23_3 IOUT_33 V_33 {rfb}
Rout_U23_3 IOUT_33 0 {rout}
Cout_U23_3 IOUT_33 0 {cout+cstray}
Cft_U23_3 REF_33 IOUT_33 {cft+1e-21}
C135 vp 0 100n ; C_U23_P
C136 vp 0 1u ; CB_U23_P
C137 vn 0 100n ; C_U23_N
C138 vn 0 1u ; CB_U23_N
R109 P0 SWP_30 150 ; RBRP_30
R110 N0 SWN_30 150 ; RBRN_30
XU52 REF_30 SWP_30 0 vp SIGNAL_EN SIGN12 vn SWN_30 TMUX6219
C139 vp 0 100n ; C_U52_P
C140 vn 0 100n ; C_U52_N
R111 SIGN12 0 100k ; RSEL_30
XU72 0 IOUT_30 vp vn V_30 V_30 vp ADA4899
C141 vp 0 100n ; C_U72_P
C142 vn 0 100n ; C_U72_N
C143 IOUT_30 V_30 {2.2e-12+cfextra} ; C_WEIGHT_30
R112 V_30 SN3 1.00k ; RSUM_30
R113 P1 SWP_31 150 ; RBRP_31
R114 N1 SWN_31 150 ; RBRN_31
XU53 REF_31 SWP_31 0 vp SIGNAL_EN SIGN13 vn SWN_31 TMUX6219
C144 vp 0 100n ; C_U53_P
C145 vn 0 100n ; C_U53_N
R115 SIGN13 0 100k ; RSEL_31
XU73 0 IOUT_31 vp vn V_31 V_31 vp ADA4899
C146 vp 0 100n ; C_U73_P
C147 vn 0 100n ; C_U73_N
C148 IOUT_31 V_31 {2.2e-12+cfextra} ; C_WEIGHT_31
R116 V_31 SN3 1.00k ; RSUM_31
R117 P2 SWP_32 150 ; RBRP_32
R118 N2 SWN_32 150 ; RBRN_32
XU54 REF_32 SWP_32 0 vp SIGNAL_EN SIGN14 vn SWN_32 TMUX6219
C149 vp 0 100n ; C_U54_P
C150 vn 0 100n ; C_U54_N
R119 SIGN14 0 100k ; RSEL_32
XU74 0 IOUT_32 vp vn V_32 V_32 vp ADA4899
C151 vp 0 100n ; C_U74_P
C152 vn 0 100n ; C_U74_N
C153 IOUT_32 V_32 {2.2e-12+cfextra} ; C_WEIGHT_32
R120 V_32 SN3 1.00k ; RSUM_32
R121 P3 SWP_33 150 ; RBRP_33
R122 N3 SWN_33 150 ; RBRN_33
XU55 REF_33 SWP_33 0 vp SIGNAL_EN SIGN15 vn SWN_33 TMUX6219
C154 vp 0 100n ; C_U55_P
C155 vn 0 100n ; C_U55_N
R123 SIGN15 0 100k ; RSEL_33
XU75 0 IOUT_33 vp vn V_33 V_33 vp ADA4899
C156 vp 0 100n ; C_U75_P
C157 vn 0 100n ; C_U75_N
C158 IOUT_33 V_33 {2.2e-12+cfextra} ; C_WEIGHT_33
R124 V_33 SN3 1.00k ; RSUM_33
XU83 0 SN3 SUM3 vp vn OPA810
C159 vp 0 100n ; C_U83_P
C160 vn 0 100n ; C_U83_N
R125 SN3 SUM3 523 ; RSF_3
R126 VTRIM3 SN3 10.0k ; RTRIM_3
R127 VREF_2V5 SN3 20.0k ; RREF_3
R128 SUM3 MUTEIN3 49.9 ; RMUTE_3
XU87 DRVIN3 0 0 vp logic OUTPUT_RUN vn MUTEIN3 TMUX6219
C161 vp 0 100n ; C_U87_P
C162 vn 0 100n ; C_U87_N
R129 DRVIN3 0 100k ; RDRVB_3
XU93 DRVIN3 DRVN3 DRV3 hp hn THS3091
C163 hp 0 100n ; C_U93_P
C164 hn 0 100n ; C_U93_N
R130 DRVN3 DRV3 1.21k ; RDF_3
R131 0 DRVN3 402 ; RDG_3
R132 DRV3 b3 49.9 ; R_OUT_3
C165 vp 0 10u ; C_ROW3_P
C166 vn 0 10u ; C_ROW3_N
C167 hp 0 6.8u ; C_DRIVER3_P
C168 0 hn 6.8u ; C_DRIVER3_N
C169 vp 0 100n ; C_U30_P
C170 vp 0 1u ; CB_U30_P
C171 vn 0 100n ; C_U30_N
C172 vn 0 1u ; CB_U30_N
C173 vp 0 100n ; C_U100_P
C174 vn 0 100n ; C_U100_N
C176 vp 0 100n ; C_U101_P
C177 vn 0 100n ; C_U101_N
C179 vp 0 100n ; C_U102_P
C180 vn 0 100n ; C_U102_N
C182 vp 0 100n ; C_U103_P
C183 vn 0 100n ; C_U103_N
C185 vp 0 10u ; C_TRIMB_P
C186 vn 0 10u ; C_TRIMB_N
C187 vp 0 100n ; C_REF_IN
C188 vp 0 1u ; CB_REF_IN
C189 VREF_2V5 0 100n ; C_REF_OUT
C190 VREF_2V5 0 1u ; CB_REF_OUT
Rload0 b0 0 50
Cload0 b0 0 {cload}
Rload1 b1 0 50
Cload1 b1 0 {cload}
Rload2 b2 0 50
Cload2 b2 0 {cload}
Rload3 b3 0 50
Cload3 b3 0 {cload}
.save V(a0) V(a1) V(a2) V(a3) V(b0) V(b1) V(b2) V(b3) V(P0) V(N0) V(V_00) V(SUM0) V(DRV0) V(VTRIM0) I(Rload0)
.ac dec 100 10 1G
.end
