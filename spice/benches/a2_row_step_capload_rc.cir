* Reproducible circuit-level LTspice bench. See MODEL_SCOPE.txt.
.include "../models/opa810/opa810_a.lib"
.include "../models/ths3091_tina/THS3091.lib"
.include "../models/ADA4899.sub"
.include "../models/tmux6219/TMUX6219/TMUX6219.lib"
.include "../models/opa197/OPAx197.LIB"
.param rfb=6k rout=6k cout=35p cstray=5p cfextra=0.3p cload=20p cft=0
VP vp 0 5
VN vn 0 -5
VHP hp 0 15
VHN hn 0 -15
VL logic 0 3.3
VEN SIGNAL_EN 0 3.3
VRUN OUTPUT_RUN 0 3.3
VREF VREF_2V5 0 2.5
.include "../models/TMUX6219_static_RC.lib"
.options plotwinsize=0 numdgt=7 reltol=0.0001 abstol=1p vntol=1u
VIN a0 0 PULSE(0 1 0.5u 10n 10n 1u 4u)
Rin a0 ai 33
Rb a0 0 1Meg
Xbuf ai buf buf vp vn OPA810
Rp1 buf pd 499
Rp2 pd 0 499
Xpos pd pi p vp vn OPA810
Rpf p pi 1k
Rpg pi 0 1k
Xneg 0 ni neg vp vn OPA810
Rni buf ni 1k
Rnf neg ni 1k
Rbrp0 p sp0 150
Rbrn0 neg sn0 150
XSW0 ref0 sp0 sn0 0 TMUX6219_RC
Rref0 ref0 0 6k
Cref0 ref0 0 5p
Rbrp1 p sp1 150
Rbrn1 neg sn1 150
XSW1 ref1 sp1 sn1 0 TMUX6219_RC
Rref1 ref1 0 6k
Cref1 ref1 0 5p
Rbrp2 p sp2 150
Rbrn2 neg sn2 150
XSW2 ref2 sp2 sn2 0 TMUX6219_RC
Rref2 ref2 0 6k
Cref2 ref2 0 5p
Rbrp3 p sp3 150
Rbrn3 neg sn3 150
XSW3 ref3 sp3 sn3 0 TMUX6219_RC
Rref3 ref3 0 6k
Cref3 ref3 0 5p

Gdac 0 inn ref0 0 {q/rfb}
Rfb weight inn {rfb}
Rout inn 0 {rout}
Co inn 0 {cout+cstray}
Cf weight inn {2.2p+cfextra}
Xamp 0 inn vp vn weight weight vp ADA4899
Rsum weight snode 1k
Ecopy1 copy1 0 weight 0 1
Rsum1 snode copy1 1k
Ecopy2 copy2 0 weight 0 1
Rsum2 snode copy2 1k
Ecopy3 copy3 0 weight 0 1
Rsum3 snode copy3 1k
Rt snode trim 10k
Vtrim trim 0 -1.25
Rref snode VREF_2V5 20k
Rsf sum snode 523
Xsum 0 snode sum vp vn OPA810
Rmute sum ms 49.9
XMUX drv ms 0 0 TMUX6219_RC
Rbias drv 0 100k
Xdrv drv dn dout hp hn THS3091
Rdf dout dn 1210
Rdg dn 0 402
Rser dout b0 49.9
Rl b0 0 50
Cl b0 0 1e-09
.save V(a0) V(ref0) V(weight) V(sum) V(dout) V(b0)
.param q=0.9795498652528407
Cfeed ref0 inn {cft+1e-21}
.tran 0 2.5u 0 3n
.end
