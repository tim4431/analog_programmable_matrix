* Reproducible circuit-level LTspice bench. See MODEL_SCOPE.txt.
.include "../models/opa810/opa810_a.lib"
.include "../models/ths3091_tina/THS3091.lib"
.include "../models/ADA4899.sub"
.include "../models/tmux6219/TMUX6219/TMUX6219.lib"
.include "../models/opa197/OPAx197.LIB"
.param rfb=6k rout=6k cout=35p cstray=5p cfextra=0.3p cload=20p cft=0
VP vp 0 5
VN vn 0 -5
VHP hp 0 15
VHN hn 0 -15
VL logic 0 3.3
VEN SIGNAL_EN 0 3.3
VRUN OUTPUT_RUN 0 3.3
VREF VREF_2V5 0 2.5
.options plotwinsize=0 numdgt=7 reltol=0.0001 abstol=1p vntol=1u
Gdac 0 inn VREF_2V5 0 {0.5/rfb}
Rfb out inn {rfb}
Rout inn 0 {rout}
Co inn 0 {cout+cstray}
Cf out inn 100p
Xamp 0 inn vp vn out OPAx197
Rload out 0 10k
.save V(out) V(inn)
.op
.end
