Local loop return ratio and closed-loop transient checks
.include "../models/ADA4899.sub"
.include "../models/opa810/opa810_a.lib"
.include "../models/ths3091_tina/THS3091.lib"
.include "../models/opa197/OPAx197.LIB"
VP vp 0 5
VN vn 0 -5
VHP hp 0 15
VHN hn 0 -15
.options plotwinsize=0 numdgt=7 reltol=0.0001
.param rf=6k ro=6k co=40p cf=2.5p cl=20p
XAMP 0 inn vp vn raw raw vp ADA4899
RF out inn {rf}
RO inn 0 {ro}
CO inn 0 {co}
CF out inn {cf}
RL out 0 1k
VTEST out raw DC 0 AC 1
.ac dec 150 10 3G
.save V(out) V(raw)
.step param rf list 4k 6k 8k
.step param ro list 2k 6k 1G
.step param co list 35p 70p 100p
.end
